* CMOS Inverter ML Dataset Factory - PRODUCTION VERSION
.options plotwinsize=0 numdgt=15

* --- 1. PARAMETER TABLE ---
* Ensure 'Meg' is used for MHz.
.param supply = table(run, 0,1.2, 1,1.5, 2,1.8, 3,1.0, 4,1.2, 5,1.5)
.param cap    = table(run, 0,20f, 1,50f, 2,100f, 3,10f, 4,40f, 5,80f)
.param freq   = table(run, 0,100Meg, 1,100Meg, 2,100Meg, 3,200Meg, 4,200Meg, 5,200Meg)
.param slew   = table(run, 0,50p, 1,50p, 2,50p, 3,100p, 4,100p, 5,100p)

.param Tperiod={1/freq}
.param Trf={slew}

* --- 2. THE SWEEP ---
.step param run 0 5 1

* --- 3. CIRCUIT ---
V1 VDD 0 {supply}
V2 IN 0 PULSE(0 {supply} {Tperiod} {Trf} {Trf} {Tperiod/2-Trf} {Tperiod})

* Added area/perimeter (AD, AS, PD, PS) to eliminate warnings and improve accuracy
M1 OUT IN VDD VDD PMOS L=0.18u W=0.72u AD={0.72u*0.5u} AS={0.72u*0.5u} PD={2*0.72u+1u} PS={2*0.72u+1u}
M2 OUT IN 0 0 NMOS L=0.18u W=0.36u AD={0.36u*0.5u} AS={0.36u*0.5u} PD={2*0.36u+1u} PS={2*0.36u+1u}
C1 OUT 0 {cap}

* --- 4. MODELS (BSIM3 / Level 8) ---
* Changed VTO to VTH0 (BSIM standard)
.model NMOS NMOS(Level=8 VTH0=0.4 Tox=4n)
.model PMOS PMOS(Level=8 VTH0=-0.4 Tox=4n)

* --- 5. SIMULATION ---
.tran {4*Tperiod}

* --- 6. MEASUREMENTS ---
* Power: Integrated over the 2nd and 3rd cycles for perfect stability.
*.meas TRAN P_avg AVG -V(VDD)*I(V1) FROM {Tperiod} TO {3*Tperiod}
.meas TRAN P_avg AVG -V(VDD)*I(V1) FROM {Tperiod} TO {4*Tperiod}

* Fall Delay (tphl)
.meas TRAN t_fall
+ TRIG V(IN)  VAL={supply*0.5} TD={Tperiod} RISE=1
+ TARG V(OUT) VAL={supply*0.5} TD={Tperiod} FALL=1

* Rise Delay (tplh)
.meas TRAN t_rise
+ TRIG V(IN)  VAL={supply*0.5} TD={1.5*Tperiod} FALL=1
+ TARG V(OUT) VAL={supply*0.5} TD={1.5*Tperiod} RISE=1

.end
