* CMOS Inverter ML Dataset Factory - Final 5,000-Run Version
* Optimized for accuracy, speed, and automated parsing.

.options plotwinsize=0 numdgt=15

* --- 1. DATASET PARAMETERS ---
* This includes the 5,000 randomized rows you generated in Python.
.inc params.inc

* Calculate timing per run based on the table's 'freq' and 'slew'
.param Tperiod={1/freq}
.param Trf={slew}

* --- 2. CIRCUIT TOPOLOGY ---
V1 VDD 0 {supply}
* Signal starts after 1 period to allow DC convergence
V2 IN 0 PULSE(0 {supply} {Tperiod} {Trf} {Trf} {Tperiod/2-Trf} {Tperiod})

* Transistors with Area/Perimeter (fixes warnings and adds physical realism)
M1 OUT IN VDD VDD PMOS L=0.18u W=0.72u AD={0.72u*0.5u} AS={0.72u*0.5u} PD={2*0.72u+1u} PS={2*0.72u+1u}
M2 OUT IN 0 0 NMOS L=0.18u W=0.36u AD={0.36u*0.5u} AS={0.36u*0.5u} PD={2*0.36u+1u} PS={2*0.36u+1u}
C1 OUT 0 {cap}

* --- 3. BSIM3 MODELS (Level 8) ---
.model NMOS NMOS(Level=8 VTH0=0.4 Tox=4n)
.model PMOS PMOS(Level=8 VTH0=-0.4 Tox=4n)

* --- 4. THE SWEEP EXECUTION ---
* Matches the 5,000 entries in params.inc (Index 0 to 4999)
.step param run 0 4999 1
.tran {4*Tperiod}

* --- 5. AUTOMATED MEASUREMENTS ---
* Power: Average over 2 switching cycles (from 1st period to 3rd)
.meas TRAN P_avg AVG -V(VDD)*I(V1) FROM {Tperiod} TO {3*Tperiod}

* Fall Delay: Trigger 50% Rise IN -> 50% Fall OUT
.meas TRAN t_fall
+ TRIG V(IN)  VAL={supply*0.5} TD={Tperiod} RISE=1
+ TARG V(OUT) VAL={supply*0.5} TD={Tperiod} FALL=1

* Rise Delay: Trigger 50% Fall IN -> 50% Rise OUT
.meas TRAN t_rise
+ TRIG V(IN)  VAL={supply*0.5} TD={1.5*Tperiod} FALL=1
+ TARG V(OUT) VAL={supply*0.5} TD={1.5*Tperiod} RISE=1

.end
